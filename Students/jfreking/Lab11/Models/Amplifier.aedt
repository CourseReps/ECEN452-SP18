# Ansys Electronics Desktop project, version 2018.0
project variables:
  $width = 2.99067mm
materials:
  FR4_epoxy: permittivity=4.4 dielectric_loss_tangent=0.02
  copper: permeability=0.999991 conductivity=58000000

design Circuit1 (Circuit)
options: SParamCircuitDef IntegrationMethod=FFT
components:
  V8 = V_DC(DC=10V)
  C23 = CAP_(C=1e-006farad)
  C1 = CAP_(C=1e-006farad)
  R65 = RES_(R=100)
  C2 = CAP_(C=1e-006farad)
  R1 = RES_(R=1k)
  L1 = IND_(L=1e-005)
  R133 = RES_(R=600)
  C3 = CAP_(C=1e-006farad)
  L2 = IND_(L=1e-005)
  R3 = RES_(R=10k)
  R2 = RES_(R=10)
  A162 = MS_TRL(W=width P=8.16824mm)
  A163 = MSCROSS_NX(W1=width W2=width W3=width W4=width)
  A166 = MS_TEEC(W1=width W2=width W3=width)
  A167 = MS_TEEC(W1=width W2=width W3=width)
  A168 = MS_TEEC(W1=width W2=width W3=width)
  A1 = MS_TEEC(W1=width W2=width W3=width)
  Q274 = Level01_NPN(MOD=SimpleNPN)
  QData275 = Level01_NPN_Model(ModelName=SimpleNPN)
  port Port1 pnum=1 rz=50ohm iz=0ohm noisetemp=16.85 noisetemporig=16.85cel
  port Port2 pnum=2 rz=50ohm iz=0ohm noisetemp=16.85 noisetemporig=16.85cel
nets:
  0: V8.1, R65.0, C2.0, R3.0
  net_18: V8.0, R1.1
  net_19: R133.0, C3.1
  net_21: L2.0, R3.1
  net_23: R65.1, C2.1, R2.0
  net_24: C23.0, A162.1
  net_25: R2.1, Q274.2
  net_26: A166.0, Q274.0
  net_28: A163.2, Q274.1
  net_29: C3.0, A167.2
  net_30: A163.1, A167.0
  net_31: C23.1, A163.0
  net_32: L2.1, A163.3
  net_33: L1.0, A167.1
  net_35: R1.0, A168.1
  net_36: R133.1, A1.2
  net_37: A166.2, A1.0
  net_38: C1.0, A166.1
  net_39: L1.1, A168.2
  net_40: A168.0, A1.1
  Port1: A162.0
  Port2: C1.1
setups:
  LinearFrequency: LinearFrequencyData(false, 0.1, false, "", false) SweepDefinition{Variable=F Data="LIN 0.1GHz 10GHz 0.01GHz"}
reports:
  Magnitude: dB(S(Port1,Port1)), dB(S(Port1,Port2)), dB(S(Port2,Port1)), dB(S(Port2,Port2)) vs F on LinearFrequency : LinearFrequency
  Phase: ang_deg(S(Port2,Port2)), ang_deg(S(Port1,Port1)), ang_deg(S(Port1,Port2)), ang_deg(S(Port2,Port1)) vs F on LinearFrequency : LinearFrequency
  VSWR: VSWR(Port1) vs F on LinearFrequency : LinearFrequency
  S Parameter Chart 1: S(Port1,Port1) on LinearFrequency : LinearFrequency [F=all]
  S-Parameters: S(Port1,Port1) on LinearFrequency : LinearFrequency [F=all]; KCS, KCL on LinearFrequency : LinearFrequency [F=2.5GHz]
  S-Parameters1: S(Port1,Port1) on LinearFrequency : LinearFrequency [F=all]; GACS(gain=10dB) on LinearFrequency : LinearFrequency [F=0.1GHz]

design Grounded (Circuit)
options: SParamCircuitDef IntegrationMethod=FFT
components:
  S195 = sga-348626()
  C196 = CAP_(C=1e-009)
  C197 = CAP_(C=1e-006)
  R200 = RES_(R=200)
  V201 = V_DC(DC=10V)
  C1 = CAP_(C=2.2e-011)
  C2 = CAP_(C=5.6e-011)
  C3 = CAP_(C=5.6e-011)
  A247 = MS_TRL(W=0.027414mm P=18.2725mm)
  A248 = MS_TRL(W=2.99067mm P=16.3365mm)
  A1 = MS_TRL(W=2.99067mm P=16.3365mm)
  A276 = MS_TEEC(W2=2.99mm W3=2.99mm W1=0.0274mm)
  port Port1 pnum=1 rz=50ohm iz=0ohm
  port Port2 pnum=2 rz=50ohm iz=0ohm
nets:
  0: C196.1, C197.1, V201.1, C1.1
  net_11: A276.0, C3.0
  net_12: A276.1, A1.1
  net_15: A276.2, A247.0
  net_19: R200.0, V201.0
  net_20: C196.0, C197.0, R200.1, C1.0, A247.1
  net_21: C2.1, A248.0
  net_22: S195.0, A248.1
  net_23: S195.1, A1.0
  Port1: C2.0
  Port2: C3.1
setups:
  LinearFrequency: LinearFrequencyData(false, 0.1, false, "", false) SweepDefinition{Variable=F Data="LINC 0.1GHz 5GHz 50"}
reports:
  S Parameter Plot 1: dB(S(Port1,Port1)), dB(S(Port1,Port2)), dB(S(Port2,Port1)), dB(S(Port2,Port2)) vs F on LinearFrequency : LinearFrequency; markers S21 at 2.5GHz, S22 at 2.5GHz, S11 at 2.5GHz, S12 at 2.5GHz
  VSWR Plot 1: VSWR(Port1), VSWR(Port2) vs F on LinearFrequency : LinearFrequency; markers Port 1 at 2.5GHz, Port 2 at 2.5GHz
  S Parameter Chart 1: S(Port1,Port1), S(Port2,Port2), S(Port1,Port2) on LinearFrequency : LinearFrequency [F=all]
  S Parameter Chart 2: S(Port2,Port1) on LinearFrequency : LinearFrequency [F=all]
  Gain Plot 1: MSG, GMAX vs F on LinearFrequency : LinearFrequency
  Stability Plot 1: K vs F on LinearFrequency : LinearFrequency
  Gain Plot 2: GA vs F on LinearFrequency : LinearFrequency

design RadialStub (Circuit)
options: SParamCircuitDef IntegrationMethod=FFT
components:
  A4 = MS_TRL(W=2.99067mm P=16.3365mm)
  V201 = V_DC(DC=10V)
  S195 = sga-348626()
  A234 = MSRSTL_NX(LS=16.3365mm A=90deg WI=0.027414mm)
  A235 = MSRSTL_NX(LS=16.3365mm A=90deg WI=0.027414mm)
  A247 = MS_TRL(W=0.027414mm P=18.2725mm)
  C1 = CAP_(C=2.2e-011)
  C197 = CAP_(C=1e-006)
  C196 = CAP_(C=1e-009)
  A1 = MSRSTL_NX(LS=16.3365mm A=90deg WI=0.027414mm)
  A2 = MS_TRL(W=2.99067mm P=16.3365mm)
  R271 = RES_(R=200)
  C272 = CAP_(C=5.6e-011)
  C273 = CAP_(C=5.6e-011)
  A277 = MSTEEE_NX(W1=2.99mm W2=2.99mm W3=0.0274mm)
  port Port1 pnum=1 rz=50ohm iz=0ohm noisetemp=16.85 noisetemporig=16.85cel
  port Port2 pnum=2 rz=50ohm iz=0ohm noisetemp=16.85 noisetemporig=16.85cel
nets:
  0: V201.1
  net_13: A4.1, S195.0
  net_14: A2.1, A277.1
  net_15: A247.1, C1.0, C197.0, C196.0, R271.1
  net_16: C272.0, A277.0
  net_17: A247.0, A277.2
  net_18: A234.0, C196.1
  net_19: A235.0, C1.1
  net_20: C197.1, A1.0
  net_21: S195.1, A2.0
  net_23: A4.0, C273.1
  net_3: V201.0, R271.0
  Port1: C273.0
  Port2: C272.1
setups:
  LinearFrequency: LinearFrequencyData(false, 0.1, false, "", false) SweepDefinition{Variable=F Data="LINC 0.1GHz 5GHz 50"}
reports:
  S Parameter Plot 1: dB(S(Port2,Port2)), dB(S(Port2,Port1)), dB(S(Port1,Port2)), dB(S(Port1,Port1)) vs F on LinearFrequency : LinearFrequency; markers S21 at 2.5GHz, S22 at 2.5GHz, S11 at 2.5GHz, S12 at 2.5GHz
  VSWR Plot 1: VSWR(Port2), VSWR(Port1) vs F on LinearFrequency : LinearFrequency; markers Port 1 at 2.5GHz, Port 2 at 2.5GHz
  S Parameter Chart 1: S(Port2,Port2), S(Port1,Port2), S(Port1,Port1) on LinearFrequency : LinearFrequency [F=all]
  S Parameter Chart 2: S(Port2,Port1) on LinearFrequency : LinearFrequency [F=all]
  Stability Plot 1: K vs F on LinearFrequency : LinearFrequency
  S-Parameters: S(Port2,Port2) on LinearFrequency : LinearFrequency [F=all]
